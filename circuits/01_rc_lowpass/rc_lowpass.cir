* 01 - First-Order RC Low-Pass Filter
* ------------------------------------
* R = 10 kOhm, C = 10 nF
* Theoretical cutoff: fc = 1 / (2*pi*R*C) = 1.5915 kHz
* Expected rolloff:   -20 dB/decade above fc
* Expected phase:     -45 degrees at fc

V1 in 0 DC 0 AC 1
R1 in out 10k
C1 out 0 10n

.control
ac dec 100 10 10meg
wrdata rc_lowpass_ac.txt vdb(out) vp(out)
quit
.endc

.end
